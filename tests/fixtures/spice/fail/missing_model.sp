missing model
d1 n1 0 nosuchmodel
m1 n1 n2 0 0
r1 n1 0 1k
.end

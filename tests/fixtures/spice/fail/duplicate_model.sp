two model cards of one name in ONE scope
.model dm d is=1e-14
.model dm d is=2e-14
d1 n1 0 dm
r1 n1 0 1k
.end

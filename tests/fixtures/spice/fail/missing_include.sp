missing include
.include "nowhere.inc"
x1 n1 0 ghost
r1 n1 0 1k
.end

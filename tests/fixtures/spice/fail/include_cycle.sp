include cycle
.include "cyc_a.inc"
r1 n1 0 1k
.end

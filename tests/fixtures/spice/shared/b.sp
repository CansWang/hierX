deck b uses the same shared library
.include "lib.inc"
XDUT p1 p2 dut
v1 p1 0 2
.end

deck a uses the shared library
.include "lib.inc"
XDUT n1 n2 dut
v1 n1 0 1
.end

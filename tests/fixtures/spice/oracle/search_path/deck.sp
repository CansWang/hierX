search-path include and a control block inside an include
.include "only_here.inc"
.include "with_control.inc"
x1 n1 n2 shared
r0 n2 0 1k
v1 n1 0 1
.end

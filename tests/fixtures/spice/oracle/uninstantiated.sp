a definition the deck never instantiates
.subckt unused a b
r1 a b 1k
.ends
r1 n1 0 1k
v1 n1 0 1
.end

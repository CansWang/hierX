Xyce coupling and specialized sources
V1 a 0 1
L1 a b 1u
L2 b c 2u
L3 c 0 3u
K1 L1 L2 L3 0.9
YACC motion acceleration velocity position
R1 acceleration 0 1k
R2 velocity 0 1k
R3 position 0 1k
.op
.end
